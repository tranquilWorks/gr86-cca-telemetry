I32 exploratory network alternative; not manufacturer U151 model
.include "lm63615_derivative.lib"

.func if(c,a,b) {c ? a : b}
.model d_small D(Is=1n N=1.5 Rs=.02)
.model d_body D(Is=1n N=1.3 Rs=.02 Cjo=100p)
.param CAP_SCALE=1 RDS_SCALE=1 IUP=35u TON=32m OVREF=.5 UVREF=.5 HYS=.025
.param CABLE_L=1u CABLE_R=.1 CgsQ=910p CgdQ=100p
VBAT BAT 0 PWL(0 0 1m 0 2m 12)
Rcable BAT cable_r {CABLE_R}
Lcable cable_r RAW_12V {CABLE_L}
Rfuse RAW_12V FUSED_12V 0.05
D101 FUSED_12V REV_BLOCKED_12V d_small
R101 REV_BLOCKED_12V PROTECT_CTRL_VIN 12.1k
C101 PROTECT_CTRL_VIN 0 {100n*CAP_SCALE}
Bctrl PROTECT_CTRL_VIN 0 I={30u*clip(v(PROTECT_CTRL_VIN)/2.5,0,1)}
Bctrlout PROTECTED_12V 0 I={40u*clip(v(PROTECTED_12V)/2.5,0,1)}
BD102 PROTECT_CTRL_VIN 0 I={max((v(PROTECT_CTRL_VIN)-36.8)/1.4,0)}
R102 REV_BLOCKED_12V INPUT_UV 549k
R103 INPUT_UV INPUT_OV 24.3k
R104 INPUT_OV 0 14.7k
R105 PROTECT_CTRL_VIN INPUT_SHDN 510k
Rshdn INPUT_SHDN 0 1e12
Vlogic one 0 1
S_input_uv one uv_ok INPUT_UV 0 input_uv_sw
R_input_uv uv_ok 0 1k
.model input_uv_sw SW(Ron=0.01 Roff=1e12 Vt={UVREF+HYS/2} Vh={HYS/2})
Sov one ov_bad INPUT_OV 0 ov_sw
Rov ov_bad 0 1k
.model ov_sw SW(Ron=0.01 Roff=1e12 Vt={OVREF-HYS/2} Vh={HYS/2})
Bpvalid pvalid 0 V={if(v(uv_ok)>0.5 && v(ov_bad)<0.5 && v(PROTECT_CTRL_VIN)>2.4 && v(INPUT_SHDN)>1.2,1,0)}
* Charge ptimer is computational state, not an added physical capacitor.
B_p_timer 0 ptimer I={if(v(pvalid)>0.5,if(v(ptimer)<1.02,1u,0),-v(ptimer)/1)}
C_p_timer ptimer 0 {TON*1u} IC=0
R_p_timer ptimer 0 1e12
Ballow allow 0 V={if(v(pvalid)>0.5 && v(ptimer)>1,1,0)}
* 2us assumed fast-path RC lag; 6us fast-off delay screened separately by parameter.
Rdelay allow allow_d 1
Cdelay allow_d 0 2.885u
* Gate source follows the datasheet pullup current and 11V overdrive; fault discharges.
Bgate 0 INPUT_GATE_DRIVE I={if(v(allow_d)>0.5,IUP*clip((v(PROTECTED_12V)+11-v(INPUT_GATE_DRIVE)),0,1),-clip(v(INPUT_GATE_DRIVE,PROTECTED_12V)/10,0,0.06))}
R106 INPUT_GATE_DRIVE INPUT_GATE 10
R107 INPUT_GATE_DRIVE INPUT_GATE_SLEW 5.1k
C102 INPUT_GATE_SLEW 0 {10n*CAP_SCALE}
Rgate INPUT_GATE PROTECTED_12V 1e9
* Level-1 MOS fit to typical Rds_on/Vth. NOT ST's proprietary transistor model.
M_Q101 REV_BLOCKED_12V INPUT_GATE qsrc qsrc n_q101 W=1 L=1
.model n_q101 NMOS(LEVEL=1 VTO=3 KP=5 LAMBDA=0)
Rq101 qsrc PROTECTED_12V {0.075*RDS_SCALE}
Cqgs INPUT_GATE qsrc {CgsQ}
Cqgd INPUT_GATE REV_BLOCKED_12V {CgdQ}
Cqds REV_BLOCKED_12V qsrc 167p
Dqbody qsrc REV_BLOCKED_12V d_body
BD104 INPUT_GATE PROTECTED_12V I={max((v(INPUT_GATE,PROTECTED_12V)-15)/2,0)}
D104forward PROTECTED_12V INPUT_GATE d_small
BD103 PROTECTED_12V 0 I={max((v(PROTECTED_12V)-29.5)/0.244,0)}
C103 PROTECTED_12V 0 {2.2u*CAP_SCALE}
R111 PROTECTED_12V 0 100k
R109 PROTECTED_12V BUCK_FEED 0.005
R110 BUCK_FEED VIN5 0.47
C121 VIN5 0 {2.2u*CAP_SCALE}
C122 VIN5 0 {2.2u*CAP_SCALE}
C123 VIN5 0 {100n*CAP_SCALE}
C129 VIN5 0 {2.2u*CAP_SCALE}

R125 VIN5 EN5 100k
R126 EN5 0 26.1k
S5en one on5 EN5 0 en5_sw
R5en on5 0 1k
.model en5_sw SW(Ron=.01 Roff=1e12 Vt=1.45 Vh=.05)
* U121 fitted compensation/ripple passives retained, but averaged switch waveform.
* Effective reference 5/4.09 is calibrated to vendor REPLAY at 10.688V, not TI Vref.
XU121 VIN5 sw5 source5 fb5 on5 U151_DERIV PARAMS: VREF=1.1613691931540342 TSS=.003 TDELAY=0
+ TFPWM=.008 KP=32 FZ=3000 FP=80000 TI=2.5u LNOM=47u IPOS=0.95 INEG=0 ETA=.8
L121 sw5 winding5 4.7e-05
R_L121 winding5 source5 0.15109
C127 source5 c127r 1.1e-05
R_C127 c127r 0 .01
C128 source5 c128r 1.1e-05
R_C128 c128r 0 .01
R122 source5 fb5 309k
R123 fb5 0 100k
R124 sw5 ripple5 43.2k
C125 ripple5 source5 3.3n
C126 ripple5 fb5 100p
R128 source5 rail5 .005
* Controlled reverse-blocking load switch, NOT its vendor transistor model.
* 5V PGOOD: min/max crossings swept separately. 100us fall lag is allocation.
R151 rail5 feediso .005
Sgood5 one good5 iso_en_pin 0 good5model
Rgood5 good5 0 1k
.model good5model SW(Ron=.01 Roff=1e12 Vt=0.6950000000000001 Vh=0.05499999999999999)
Bgooddelay 0 gooddelay I={(v(good5)-v(gooddelay))/(v(good5)>v(gooddelay) ? 0.0001442695416700931 : 0.0003606738541752327)}
Cgooddelay gooddelay 0 1 IC=0
Bage 0 ageiso I={v(switchon)>.5 ? 1 : -v(ageiso)/1u}
Cageiso ageiso 0 1 IC=0
Rageiso ageiso 0 1e12
Bvslew slewiso 0 V={min(max((v(ageiso)-0.0005)/0.00876628,0),max(v(feediso),0))}
* Conductance servo only models slew-limited turn-on. It has no artificial current limit.
Vpass feediso feedpass 0
Bpass feedpass vin I={v(switchon)>.5 ? v(feediso,vin)*(v(feediso,vin)<0 ? 1/0.04 : min(1/0.04,max(v(slewiso,vin),0)*1e6)) : -0.0001*clip(v(vin),0,1)}
Bbias feediso 0 I={50u*clip(v(feediso),0,1)}

R160 vin snsiso 6360.9220000000005
R161 snsiso 0 997.5
Bic151 vin 0 I={10u*clip(v(vin),0,1)}
* Reserve additional leakage for both MLCC banks and board, independent of switch allocation.
Bcapleak vin 0 I={0.0094*clip(v(vin),0,1)}
Sgoodlocal one localgood snsiso 0 snsmodel
Rgoodlocal localgood 0 1k
.model snsmodel SW(Ron=.01 Roff=1e12 Vt=0.5325 Vh=0.03249999999999997)

Bsnsfilter 0 snsfiltered I={(v(localgood)-v(snsfiltered))/7.213477083504654e-06}
Csnsfilter snsfiltered 0 1 IC=0
Bsnsprev 0 snsprev I={(v(snsfiltered)-v(snsprev))/1u}
Csnsprev snsprev 0 1 IC=0
Bsnsevent snsevent 0 V={clip((v(snsprev)-v(snsfiltered)-.02)/.01,0,1)*clip((.5-v(snsfiltered))/.01,0,1)}
Brestart 0 restartage I={-v(snsevent)*v(restartage)/10n + (1-v(snsevent))*clip((.1-v(restartage))/.001,0,1)}
Crestart restartage 0 1 IC=0
Rrestart restartage 0 1e12
Bswitchon switchon 0 V={v(gooddelay)>.5 && v(restartage)>0.002 ? 1 : 0}
Bpgwant pgwant 0 V={min(v(localgood),v(switchon))}
Bpgdelay 0 pgdelay I={(v(pgwant)-v(pgdelay))/(v(pgwant)>v(pgdelay) ? 0.0001442695416700931 : 7.213477083504654e-06)}
Cpgdelay pgdelay 0 1 IC=0
Bpgsink en151 0 I={(1-clip(v(pgdelay),0,1))*v(en151)/400}
R159pull rail5 en151 47000
C165en en151 0 1.1e-07
Benleak actual_en151 0 I={300n*clip(v(en151),0,1)}
S151en one enable_ctrl actual_en151 0 en151model
R151en enable_ctrl 0 1k
.model en151model SW(Ron=.01 Roff=1e12 Vt=1.1825 Vh=0.24250000000000005)
C151 vin C151_esr 1.1e-05
R_C151 C151_esr 0 .01
C152 vin 0 2.2e-07
* Other 5V consumers and known decoupling aggregate, enabled by available voltage.
C_OTHER5 rail5 0 2.205e-05
Bother5 rail5 0 I={.0792*clip(v(rail5)/4.5,0,1)}
* shared 1V computational logic reference
Suv one enable enable_ctrl 0 uv_sw
Ruv enable 0 1k
.model uv_sw SW(Ron=.01 Roff=1e12 Vt=.5 Vh=.01)
XU151 vin sw source fb enable U151_DERIV PARAMS: VREF=1.0156 TSS=0.001 TDELAY=0
+ TFPWM=0.008 KP=14.4 FZ=1000 FP=80000 TI=3e-06 IPOS=2.4 INEG=1.49
L151 sw winding 1.5e-05
R_L151 winding source 0.114975375
C155 source C155_ESR 2.7829999999999996e-05
R_C155 C155_ESR 0 0.01
C156 source C156_ESR 2.7829999999999996e-05
R_C156 C156_ESR 0 0.01
C157 source C157_ESR 2.7829999999999996e-05
R_C157 C157_ESR 0 0.01
C158 source C158_ESR 1e-07
R_C158 C158_ESR 0 0.01
C201 main C201_ESR 2.7829999999999996e-05
R_C201 C201_ESR 0 0.01
C204 main C204_ESR 2.7829999999999996e-05
R_C204 C204_ESR 0 0.01
C202 main C202_ESR 1e-07
R_C202 C202_ESR 0 0.01
C205 main C205_ESR 1e-07
R_C205 C205_ESR 0 0.01
C301 main C301_ESR 1e-07
R_C301 C301_ESR 0 0.01
C302 main C302_ESR 1e-06
R_C302 C302_ESR 0 0.01
C404 main C404_ESR 1e-07
R_C404 C404_ESR 0 0.01
C531 main C531_ESR 1e-07
R_C531 C531_ESR 0 0.01
VR158 main branch_sense 0
Rbranch branch_sense branch_l 0.11
Lbranch branch_l branch_r 2e-07
R158 bulksw_out damped 0.3
C206 damped C206_ESR 0.0014320799999999999
R_C206 C206_ESR 0 0.025
R155 source fb 11838.94
R156 fb 0 5041.92
R153 source main_feed 0.01
Rmainfeed main_feed main_l 0.075
Lmainfeed main_l main 3e-07
R154 main 0 1000
Vload requested 0 DC .45
Bload main 0 I={0.75*clip(v(main)/2.7,0,1)}
* TPS3808G33 CT=open; normalized delay/logic is an approximation, no actual MCU.
Svalid one valid main 0 valid_sw
Rvalid valid 0 1k
.model valid_sw SW(Ron=.01 Roff=1e12 Vt=3.155000625 Vh=0.038950625000000016)
Btimer 0 timer I={v(valid)>.5 ? (v(timer)<1.01 ? 1u : 0) : -v(timer)}
Ctimer timer 0 1.8e-07 IC=0
Rtimer timer 0 1e12
Bready ready 0 V={v(valid)>.5 && v(timer)>1 ? 1 : 0}
Breset reset_ctl 0 V={1-v(ready)}
Sreset reset_raw 0 reset_ctl 0 reset_sw
.model reset_sw SW(Ron=400 Roff=1e12 Vt=.5 Vh=.01)
R203 reset_raw en 1k
R201 main en 10k
Cen en 0 20p
.options method=gear maxord=2 reltol=0.0002 abstol=1n vntol=1u
R164gate vin disg 4700
Cdisg disg 0 2e-09
Bq152gate disg 0 I={2e-05*clip(v(disg),0,1)}
Bq153gate en151 0 I={2e-05*clip(v(en151),0,1)}
Bq153 disg 0 I={v(disg)*clip((v(en151)-2.5)/.1,0,1)/0.001}
VR165 source disfeed 0
R165 disfeed disdrain 4.7
Bq152 disdrain 0 I={v(disdrain)*clip((v(disg)-2.5)/.1,0,1)/0.001}
Dq152body 0 disdrain body_diode

R166en en151 actual_en151 310200.0
R167en actual_en151 0 349800.0
Cen151 actual_en151 0 2e-11
R162phys rail5 iso_en_pin 4711.75
R163phys iso_en_pin 0 997.5
Biso_en_leak iso_en_pin 0 I={1e-07*clip(v(iso_en_pin),0,1)}
Bsns_leak snsiso 0 I={1e-07*clip(v(snsiso),0,1)}

Rhold vin hold_l 0.06
Lhold hold_l hold_bus 3e-07
R_C162 hold_bus c162 0.1
C162 c162 0 0.00021056

C161phys feediso 0 100n
R169 bulk_en_in bulk_en_pin 3019.0299999999997
R170 bulk_en_pin 0 997.5
Rbulk_en_in main bulk_en_in .001
Bbulk_en_leak bulk_en_pin 0 I={1e-07*clip(v(bulk_en_pin),0,1)}
Sbulk_en one bulk_want bulk_en_pin 0 bulk_enmodel
Rbulk_want bulk_want 0 1k
.model bulk_enmodel SW(Ron=.01 Roff=1e12 Vt=0.6950000000000001 Vh=0.05499999999999999)
Bbulk_delay 0 bulk_enabled I={(v(bulk_want)-v(bulk_enabled))/0.0001442695416700931}
Cbulk_delay bulk_enabled 0 1 IC=0
Bbulk_age 0 bulk_age I={v(bulk_enabled)>.5 ? 1 : -v(bulk_age)/1u}
Cbulk_age bulk_age 0 1 IC=0
Rbulk_age bulk_age 0 1e12
Bbulk_slew bulk_slew 0 V={min(max((v(bulk_age)-.0005)/0.018046879999999998,0),max(v(branch_r),0))}
Vbulkpass branch_r bulk_feed 0
Bbulkpass bulk_feed bulksw_out I={v(bulk_enabled)>.5 ? v(bulk_feed,bulksw_out)*(v(bulk_feed,bulksw_out)<0 ? 1/0.06 : min(1/0.06,max(v(bulk_slew,bulksw_out),0)*1e6)) : -100u*clip(v(bulksw_out),0,1)}
Bbulk_bias main 0 I={50u*clip(v(main),0,1)}
Rbulk_localcap branch_r bulk_localcap .01
C167phys bulk_localcap 0 1e-06
R168bleed damped 0 1000
Bbulk_capleak damped 0 I={0.008568*clip(v(damped),0,1)}

.control
set wr_vecnames
set wr_singlescale
save v(vin) v(source) v(main) i(L151) v(fb) v(en) v(ready) v(xu151.ref) v(xu151.cmd) i(VBAT) v(enable) v(VIN5) v(source5) i(L121) v(BAT) v(switchon) v(restartage) v(snsevent) i(VR158) v(damped) i(Vbulkpass) v(bulksw_out) v(bulk_en_pin) v(rail5) v(PROTECTED_12V) v(good5) v(gooddelay) v(snsiso) v(pgdelay) i(Vpass) v(en151) v(disg) v(disdrain) i(VR165)
tran 2e-06 0.6 0 2e-06
wrdata waveform.tsv v(vin) v(source) v(main) i(L151) v(fb) v(en) v(ready) v(xu151.ref) v(xu151.cmd) i(VBAT) v(enable) v(VIN5) v(source5) i(L121) v(BAT) v(switchon) v(restartage) v(snsevent) i(VR158) v(damped) i(Vbulkpass) v(bulksw_out) v(bulk_en_pin) v(rail5) v(PROTECTED_12V) v(good5) v(gooddelay) v(snsiso) v(pgdelay) i(Vpass) v(en151) v(disg) v(disdrain) i(VR165)
echo I32_FINISHED
echo I32_FINISHED > completion.txt
quit
.endc
.end
